* ============================================================
* Onda cuadrada bipolar
* Comparación con cálculo RMS en Python
* ============================================================
.title Onda cuadrada bipolar

* ------------------------------------------------------------
* Parámetros
* ------------------------------------------------------------
.param Vp = 10
.param T  = 20m

* ------------------------------------------------------------
* Generador bipolar
* V1 = -10 V inicialmente
* V2 = +10 V
*
* TON = T/2
* ------------------------------------------------------------

V1 out 0 PULSE(-10 10 0 1n 1n {T/2} T)

* ------------------------------------------------------------
* Simulación
* ------------------------------------------------------------

.tran 10u 80m
* ------------------------------------------------------------
* Medidas. Se calcula sobre los dos últimos períodos
* ------------------------------------------------------------

.meas tran VAVG AVG v(out) FROM=40m TO=80m
.meas tran VRMS RMS v(out) FROM=40m TO=80m

.control
run
.endc
.end
